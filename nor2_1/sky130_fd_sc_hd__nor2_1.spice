* NGSPICE file created from sky130_fd_sc_hd__nor2_1.ext - technology: sky130A

.subckt sky130_fd_sc_hd__nor2_1 A B VGND VNB VPB VPWR Y
X0 Y.t0 B.t0 VGND.t0 VNB.t0 sky130_fd_pr__nfet_01v8 ad=0.063 pd=0.73 as=0.11925 ps=1.43 w=0.45 l=0.15
X1 a_122_281# B.t1 Y.t1 VPB.t0 sky130_fd_pr__pfet_01v8 ad=0.1134 pd=1.29 as=0.2862 ps=2.69 w=1.08 l=0.15
X2 VGND.t1 A.t0 Y.t2 VNB.t1 sky130_fd_pr__nfet_01v8 ad=0.11925 pd=1.43 as=0.063 ps=0.73 w=0.45 l=0.15
X3 VPWR.t0 A.t1 a_122_281# VPB.t1 sky130_fd_pr__pfet_01v8 ad=0.2862 pd=2.69 as=0.1134 ps=1.29 w=1.08 l=0.15
R0 B.n0 B.t1 319.459
R1 B B.n0 186.113
R2 B.n0 B.t0 125.874
R3 VGND.n0 VGND.t1 252.852
R4 VGND.n0 VGND.t0 252.745
R5 VGND VGND.n0 0.475252
R6 Y Y.t1 391.361
R7 Y Y.n0 225.351
R8 Y.n0 Y.t2 37.3338
R9 Y.n0 Y.t0 37.3338
R10 VNB.t0 VNB.t1 1291.47
R11 VNB VNB.t0 720.819
R12 VPB.t0 VPB.t1 202.968
R13 VPB VPB.t0 199.661
R14 A.n0 A.t1 285.829
R15 A A.n0 165.876
R16 A.n0 A.t0 133.195
R17 VPWR.n0 VPWR.t0 350.863
R18 VPWR.n0 VPWR 0.0230115
R19 VPWR VPWR.n0 0.00112379
C0 VPWR VPB 0.04421f
C1 VPWR Y 0.15399f
C2 B A 0.1004f
C3 Y a_122_281# 0.01159f
C4 VPB A 0.034f
C5 Y A 0.04699f
C6 VPWR a_122_281# 0.00363f
C7 VPWR A 0.06289f
C8 B VGND 0.06711f
C9 VPB VGND 0.00462f
C10 Y VGND 0.10669f
C11 VPWR VGND 0.01708f
C12 a_122_281# VGND 0
C13 VPB B 0.0383f
C14 Y B 0.08821f
C15 VGND A 0.06774f
C16 VPWR B 0.01888f
C17 Y VPB 0.01202f
C18 VGND VNB 0.24831f
C19 VPWR VNB 0.2105f
C20 Y VNB 0.0826f
C21 A VNB 0.17726f
C22 B VNB 0.18362f
C23 VPB VNB 0.3468f
.ends
