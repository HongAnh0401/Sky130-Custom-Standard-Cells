* NGSPICE file created from nand2_1.ext - technology: sky130A

.subckt sky130_fd_sc_hd__nand2_1 A B VGND VNB VPB VPWR Y
X0 VPWR.t1 A.t0 Y.t2 VPB.t1 sky130_fd_pr__pfet_01v8 ad=0.27825 pd=2.63 as=0.147 ps=1.33 w=1.05 l=0.15
X1 Y.t0 B.t0 VPWR.t0 VPB.t0 sky130_fd_pr__pfet_01v8 ad=0.147 pd=1.33 as=0.27825 ps=2.63 w=1.05 l=0.15
X2 Y.t1 A.t1 a_110_47# VNB.t0 sky130_fd_pr__nfet_01v8 ad=0.159 pd=1.73 as=0.063 ps=0.81 w=0.6 l=0.15
X3 a_110_47# B.t1 VGND.t0 VNB.t1 sky130_fd_pr__nfet_01v8 ad=0.063 pd=0.81 as=0.159 ps=1.73 w=0.6 l=0.15
R0 A.n0 A.t0 245.975
R1 A.n0 A.t1 162.745
R2 A A.n0 153.358
R3 Y Y.t1 247.447
R4 Y Y.n0 242.401
R5 Y.n0 Y.t2 26.2672
R6 Y.n0 Y.t0 26.2672
R7 VPWR.n0 VPWR.t1 266.413
R8 VPWR.n0 VPWR.t0 266.236
R9 VPWR VPWR.n0 0.475558
R10 VPB.t0 VPB.t1 246.828
R11 VPB VPB.t0 137.764
R12 B.n0 B.t0 237.445
R13 B B.n0 158.531
R14 B.n0 B.t1 157.617
R15 VNB.t1 VNB.t0 1059.53
R16 VNB VNB.t1 706.355
R17 VGND VGND.t0 247.12
C0 VPB VGND 0.00508f
C1 Y VPB 0.00489f
C2 A VPWR 0.03828f
C3 VGND VPWR 0.03316f
C4 Y VPWR 0.20114f
C5 B A 0.05724f
C6 VPB VPWR 0.05089f
C7 a_110_47# VGND 0.00274f
C8 B VGND 0.04655f
C9 Y a_110_47# 0.00634f
C10 B Y 0.04347f
C11 B VPB 0.03741f
C12 A VGND 0.0111f
C13 A Y 0.08679f
C14 A VPB 0.03613f
C15 a_110_47# VPWR 0
C16 B VPWR 0.04344f
C17 Y VGND 0.11053f
C18 VGND VNB 0.23112f
C19 Y VNB 0.05236f
C20 VPWR VNB 0.25242f
C21 A VNB 0.14496f
C22 B VNB 0.1423f
C23 VPB VNB 0.34066f
.ends
