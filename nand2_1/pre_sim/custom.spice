** sch_path: /home/daohonganh/Desktop/nand2/nand2_1_sim.sch
**.subckt nand2_1_sim
V1 VDD GND 1.8
VA A GND PULSE (0 1.8 0p 50p 50p 1000p 1n)
VB B GND PULSE (0 1.8 100p 50p 50p 100p 0.6n)
x1 VDD VDD A Y B GND GND nand2_1_cus
**** begin user architecture code

*SLEW
.measure tran trise TRIG v(Y) VAL=0.18 RISE=1 TARG v(Y) VAL=1.62 RISE=1
.measure tran tfall TRIG v(Y) VAL=1.62 FALL=1 TARG v(Y) VAL=0.18 FALL=1

*DELAY
.measure tran tpHL TRIG v(B) VAL=0.9 RISE=1 TARG v(Y) VAL=0.9 FALL=1
.measure tran tpLH TRIG v(B) VAL=0.9 FALL=1 TARG v(Y) VAL=0.9 RISE=1
.tran 1p 5n
.control
run
plot v(A) v(B) v(Y)
.endc
.end

.lib /home/daohonganh/Desktop/chip_design/pdk/share/pdk/sky130A/libs.tech/ngspice/sky130.lib.spice tt_mm

**** end user architecture code
**.ends

* expanding   symbol:  nand2_1_cus.sym # of pins=7
** sym_path: /home/daohonganh/Desktop/nand2/nand2_1_cus.sym
** sch_path: /home/daohonganh/Desktop/nand2/nand2_1_cus.sch
.subckt nand2_1_cus VPWR VPB A Y B VNB VGND
*.ipin A
*.iopin VPWR
*.iopin VPB
*.iopin VGND
*.iopin VNB
*.ipin B
*.opin Y
XM1 Y A net1 VNB sky130_fd_pr__nfet_01v8 L=0.15 W=0.6
XM2 Y B VPWR VPB sky130_fd_pr__pfet_01v8 L=0.15 W=1.05
XM3 Y A VPWR VPB sky130_fd_pr__pfet_01v8 L=0.15 W=1.05
XM4 net1 B VGND VNB sky130_fd_pr__nfet_01v8 L=0.15 W=0.6
.ends

.GLOBAL GND
.GLOBAL VDD
.end
