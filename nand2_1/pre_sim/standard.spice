.lib /home/daohonganh/Desktop/chip_design/pdk/share/pdk/sky130A/libs.tech/ngspice/sky130.lib.spice tt_mm

.include /home/daohonganh/Desktop/chip_design/pdk/share/pdk/sky130A/libs.ref/sky130_fd_sc_hd/spice/sky130_fd_sc_hd.spice

XNAND2 A B VGND VNB VPB VPWR Y sky130_fd_sc_hd__nand2_1
* Power supply
VDD  VPWR 0 1.8
VSS  VGND 0 0

* Power supply
VDD2  VPB 0 1.8
VSS2  VNB 0 0

VA A GND PULSE(0 1.8 100p 50p 50p 100p 0.6n)
VB B GND PULSE(0 1.8 100p 50p 50p 100p 1n)

*SLEW
.measure tran trise TRIG v(Y) VAL=0.18 RISE=1 TARG v(Y) VAL=1.62 RISE=1
.measure tran tfall TRIG v(Y) VAL=1.62 FALL=1 TARG v(Y) VAL=0.18 FALL=1

*DELAY
.measure tran tpHL TRIG v(B) VAL=0.9 RISE=1 TARG v(Y) VAL=0.9 FALL=1
.measure tran tpLH TRIG v(B) VAL=0.9 FALL=1 TARG v(Y) VAL=0.9 RISE=1

.tran 1p 2n
.control
run
plot v(A) v(B) v(Y)
.endc
.end
